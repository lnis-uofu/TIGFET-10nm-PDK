// VerilogA for NCSU_TechLib_FreePDK15, TIGFET_3GT, veriloga

`include "constants.vams"
`include "disciplines.vams"

module TIGFET_3GT_ALT(d,pgd,cg,pgs,s);
    inout d,pgd,cg,pgs,s;
    electrical d,pgd,cg,pgs,s;
    parameter integer n = 4;

    analog begin
            I(d,s)  <+ n * $table_model(V(pgd,s),V(pgs,s),V(cg,s),V(d,s), "Id_NW10n4G.tbl","1,1,1,1");
    end
endmodule
